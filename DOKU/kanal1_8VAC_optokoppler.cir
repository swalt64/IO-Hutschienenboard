* LTspice - Kanal1 mit ILD213T Ersatzmodell

V_I01 I01 0 SINE(0 11.314 50)

V_I5V I_5V 0 DC 5
V_3V3 3V3p 0 DC 3.3

D201 N_D201_A I01 BAS316

L200 N_D201_A N_L200_2 330u

R201 I_5V N_L200_2 3.3k
R203 N_L200_2 N_V200_2 560

D200 N_V200_2 I_5V SMBJ20A

* Optokoppler Ersatz
D_V200_12 I_5V N_V200_2 DLED_OPTO
D_V200_34 I_5V N_D201_A DLED_OPTO

B_V200_SHUNT N_V200_7 0 I = { 0.003 * max( I(D_V200_12), 0 ) * 200 }

R200 N_V200_7 0 1k
R202 N_V200_7 N_U200_1 3.3k
C200 N_U200_1 0 470n

R_V200_PULL 3V3p N_V200_7 10k

R_U200_IN N_U200_1 0 1Meg

.model BAS316 D(Is=1e-9 Rs=2 N=1.9 Cjo=2p)
.model SMBJ20A D(Is=1e-12 Rs=0.05 N=1.2 Bv=22 Ibv=1m Cjo=200p)
.model DLED_OPTO D(Is=1e-18 Rs=10 N=2 Eg=2.1)

.tran 0 200m 0 100u
.end
